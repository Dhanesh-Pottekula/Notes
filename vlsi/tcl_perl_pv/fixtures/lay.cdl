* layout extracted netlist (practice sample)
.subckt inv_x1 A Y VDD VSS
MN0 Y A VSS VSS nch w=0.2u l=0.03u
.ends
.subckt clk_gate CLK EN GCLK
+ VDD VSS
XI0 EN net1 VDD VSS inv_x1
.ends
.subckt top IN OUT CLK VSS VDD
XG CLK IN TE G VDD VSS clk_gate
.ends
.subckt fill_x8 VDD VSS
.ends
