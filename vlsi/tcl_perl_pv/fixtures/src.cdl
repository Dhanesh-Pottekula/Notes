* schematic netlist (practice sample)
.SUBCKT inv_x1 A Y VDD VSS
MN0 Y A VSS VSS nch w=0.2u l=0.03u
MP0 Y A VDD VDD pch w=0.3u l=0.03u
.ENDS
.SUBCKT clk_gate CLK EN TE
+ GCLK VDD VSS
XI0 EN net1 VDD VSS inv_x1
.ENDS
.SUBCKT top IN OUT CLK VDD VSS
XG CLK IN TE G VDD VSS clk_gate
.ENDS
